# Ansys Electronics Desktop project, version 2021.2
materials:
  vacuum: permittivity=1
  air: permittivity=1.0006 permeability=1.0000004
  copper: permeability=0.999991 conductivity=58000000

design WPT COILS (Maxwell 3D, Magnetostatic, model units mm)
geometry:
  PolygonHelix1 [copper] = user_primitive(SegmentedHelix/PolygonHelix.dll, PolygonSegments=0, PolygonRadius=3mm, StartHelixRadius=40mm, RadiusChange=0mm, Pitch=8.01mm, Turns=3, SegmentsPerTurn=36, RightHanded=1)
  Polyline1 = polyline(xyz in mm: (39.847788, 0, 24.03) (40, 8, 24) (323, 8, 24), section circle width=2mm)
  Polyline2 = polyline(z=0mm, xy in mm: (39.847788, 0) (40, -10) (300, -10), section circle width=2mm)
  region [air] = box(corner=(-140mm, -140mm, -140mm), size=(280mm, 280mm, 300mm))
  Box2 = box(corner=(140mm, -140mm, 300mm), size=(260mm, 280mm, -300mm))
  PolygonHelix1.unite(Polyline1, Polyline2)
  PolygonHelix1.subtract(Box2)
  Box3 = box(corner=(140mm, -140mm, 160mm), size=(200mm, 280mm, -300mm))
  PolygonHelix1.subtract(Box3)
  PolygonHelix1.move(0mm, 0mm, 0mm)
  PolygonHelix2 [vacuum] = user_primitive(SegmentedHelix/PolygonHelix.dll, PolygonSegments=0, PolygonRadius=3mm, StartHelixRadius=40mm, RadiusChange=0mm, Pitch=8.01mm, Turns=3, SegmentsPerTurn=36, RightHanded=1)
  PolygonHelix2.move(0mm, -20mm, -90mm)
  Polyline3 = polyline(xyz in mm: (39.847788, -20, -65.97) (40, -10, -65) (85, -10, -65))
  Polyline4 = polyline(z=-90mm, xy in mm: (39.847788, -20) (40, -30) (140, -30))
  [PolygonHelix2, Polyline3, Polyline4].move(0mm, 20mm, 60mm)
  [PolygonHelix2, Polyline4, Polyline3].move(0mm, 0mm, -5mm)
  PolygonHelix2.move(0mm, 180mm, 100mm)
  Box4 [vacuum] = box(corner=(-80mm, 100mm, -140mm), size=(160mm, 160mm, 170mm))
  PolygonHelix2.move(140mm, 140mm, 0mm)
  PolygonHelix2.move(0mm, -140mm, -120mm)
  PolygonHelix2.move(-105mm, 10mm, 0mm)
  PolygonHelix2.move(-50mm, 0mm, 0mm)
  PolygonHelix2.move(5mm, 0mm, -15mm)
mesh:
  initial mesh: GlobalCurvilinear{Apply}
