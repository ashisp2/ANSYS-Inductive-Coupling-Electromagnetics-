# Ansys Electronics Desktop project, version 2021.2
materials:
  vacuum: permittivity=1
  copper: permeability=0.999991 conductivity=58000000
  air: permittivity=1.0006 permeability=1.0000004

design Maxwell3DDesign1 (Maxwell 3D, Magnetostatic, model units mm)
variables:
  i = 5A
geometry:
  Aircoreinductor [copper] = user_primitive(SegmentedHelix/PolygonHelix.dll, PolygonSegments=0, PolygonRadius=3mm, StartHelixRadius=50mm, RadiusChange=0mm, Pitch=6.01mm, Turns=25, SegmentsPerTurn=36, RightHanded=1)
  Box1 [air] = box(corner=(200mm, -275mm, -170mm), size=(-550mm, 580mm, 500mm))
  Polyline1 = polyline(xyz in mm: (49.809735, 0, 150.25) (49.814761, 4.3003335, 147.32292) (700, -47.684863, 96.694958), section circle width=2mm)
  Box2 = box(corner=(200mm, -275mm, 330mm), size=(560mm, 580mm, -500mm))
  Aircoreinductor.subtract(Box2)
  Polyline2 = polyline(xyz in mm: (49.809735, 0, 0) (50, -10, 0) (590, -70, -130), section circle width=2mm)
  Box3 = box(corner=(200mm, -275mm, 330mm), size=(1000mm, 580mm, -500mm))
  Aircoreinductor.unite(Polyline1, Polyline2)
  Aircoreinductor.subtract(Box3)
boundaries and excitations:
  I_in: Current Faces=Aircoreinductor.face(at (200, -7.70764, 135.628)) Current=i IsSolid=false Point_out_of_terminal=false
  I_out: Current Faces=Aircoreinductor.face(at (200, -26.6667, -36.1111)) Current=i IsSolid=false Point_out_of_terminal=true
parameters:
  Matrix1: Matrix I_in: NumberOfTurns=1
mesh:
  reg: LengthBased RefineInside Objects=Box1 MaxLength=90mm
  coil: LengthBased Objects=Aircoreinductor MaxLength=30mm
  initial mesh: GlobalSurfApproximation{CurvedSurfaceApproxChoice=UseSlider SliderMeshSettings=1} GlobalCurvilinear{Apply}
setups:
  Setup1: Magnetostatic MaximumPasses=10 MinimumPasses=2 MinimumConvergedPasses=1 PercentRefinement=30 PercentError=10 RelativeResidual=1e-06 NonLinearResidual=0.001
reports:
  L Table 1: L(I_in,I_in) vs i on Setup1 : LastAdaptive
