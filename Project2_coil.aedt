# Ansys Electronics Desktop project, version 2021.2
materials:
  vacuum: permittivity=1
  copper: permeability=0.999991 conductivity=58000000
  air: permittivity=1.0006 permeability=1.0000004

design Maxwell3DDesign1 (Maxwell 3D, Magnetostatic, model units mm)
variables:
  distt = 35mm
  i = 5A
  plate = 30mm
geometry:
  PolygonHelix1 [copper] = user_primitive(SegmentedHelix/PolygonHelix.dll, PolygonSegments=0, PolygonRadius=3mm, StartHelixRadius=40mm, RadiusChange=0mm, Pitch=8.01mm, Turns=3, SegmentsPerTurn=36, RightHanded=1)
  Polyline1 = polyline(xyz in mm: (39.847788, 0, 24.03) (40, 10, 25) (190, 10, 25), section circle width=2mm)
  Polyline2 = polyline(z=0mm, xy in mm: (39.847788, 0) (40, -8) (140, -10), section circle width=2mm)
  Box1 [air, non-model] = box(corner=(-100mm, -100mm, -230mm), size=(200mm, 200mm, 400mm))
  Box2 = box(corner=(100mm, -100mm, 170mm), size=(250mm, 200mm, -400mm))
  PolygonHelix1.unite(Polyline1, Polyline2)
  PolygonHelix1.subtract(Box2)
  PolygonHelix2 [copper] = user_primitive(SegmentedHelix/PolygonHelix.dll, PolygonSegments=0, PolygonRadius=3mm, StartHelixRadius=40mm, RadiusChange=0mm, Pitch=8.01mm, Turns=3, SegmentsPerTurn=36, RightHanded=1)
  Polyline3 = polyline(xyz in mm: (39.847788, 0, 24.03) (40, 10, 25) (190, 10, 25), section circle width=2mm)
  Polyline4 = polyline(z=0mm, xy in mm: (39.847788, 0) (40, -8) (140, -10), section circle width=2mm)
  PolygonHelix2.unite(Polyline3, Polyline4)
  Box3 = box(corner=(100mm, -100mm, 170mm), size=(250mm, 200mm, -400mm))
  PolygonHelix2.subtract(Box3)
  PolygonHelix2.move(0mm, 0mm, distt)
  Rectangle1 [non-model] = rectangle(corner=(-140mm, -160mm, plate), x_size=280mm, y_size=320mm)
boundaries and excitations:
  tx_in: Current Faces=PolygonHelix1.face(at (100, -9.2, 0)) Current=i IsSolid=true Point_out_of_terminal=false
  tx_out: Current Faces=PolygonHelix1.face(at (100, 10, 25)) Current=i IsSolid=true Point_out_of_terminal=true
  rx_in: Current Faces=PolygonHelix2.face(#3428) Current=0A IsSolid=true Point_out_of_terminal=false
  rx_out: Current Faces=PolygonHelix2.face(#3427) Current=0A IsSolid=true Point_out_of_terminal=true
parameters:
  Matrix1: Matrix rx_in, tx_in: NumberOfTurns=1
mesh:
  region: LengthBased RefineInside Objects=Box1 NumMaxElem=1000 MaxLength=150mm
  coil: LengthBased Objects=[PolygonHelix1, PolygonHelix2] NumMaxElem=1000 MaxLength=30mm
  initial mesh: GlobalSurfApproximation{CurvedSurfaceApproxChoice=UseSlider SliderMeshSettings=7} GlobalCurvilinear{Apply}
setups:
  Setup1: Magnetostatic MaximumPasses=10 MinimumPasses=2 MinimumConvergedPasses=1 PercentRefinement=30 PercentError=10 RelativeResidual=1e-06 NonLinearResidual=0.001
optimetrics:
  ParametricSetup1: Parametric Sim._Setups=[Setup1]
    sweep distt: LIN 35mm 65mm 10mm
field plots:
  Mag_B1: B over a plane on Setup1 : LastAdaptive
